* PASTELLA 84 — linear power supply (+5V logic rail)
* ngspice / LTspice compatible. Matches the Circuit tab defaults: 9 Vrms secondary, C1 4700u, 1.0 A load.
* Run: ngspice -b psu.cir

.title PASTELLA84 PSU

* --- mains transformer modelled as its 9 Vrms secondary (12.73 V peak), 0.25 ohm winding resistance
Vsec  ac1 ac2  SIN(0 12.73 60)
Rw    ac1 a1   0.25

* --- bridge rectifier BR1 (4 x 1N5402-ish)
D1 a1  vraw D3A
D2 ac2 vraw D3A
D3 0   a1   D3A
D4 0   ac2  D3A
.model D3A D(Is=1e-9 N=1.8 Rs=0.02 BV=200 Cjo=50p)

* --- smoothing capacitor C1 with ESR
C1    vraw c1esr 4700u
Resr  c1esr 0 0.03

* --- 7805 behavioural model: 5 V out, 2 V dropout, current limit 3 A
B7805 vreg 0 V = min(5, max(0, V(vraw) - 2))
Rout  vreg vout 0.01
C2    vout 0 100u

* --- load (Circuit tab: 0.1 .. 3.0 A)
.param ILOAD=1.0
Rload vout 0 {5/ILOAD}

.tran 50u 200m 100m
.measure tran vpk  MAX V(vraw)
.measure tran vmin MIN V(vraw)
.measure tran vrip PARAM='vpk-vmin'
.measure tran v5min MIN V(vout)
.end
